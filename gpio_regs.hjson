{
    name: "gpio"
    clock_primary: "clk_i"
    reset_primary: "rst_ni"
    param_list: [
        {name: GPIORegCount
         default: "2"}
    ]
    bus_interfaces: [
        { protocol: "reg_iface", direction: "device"}
    ]
    regwidth: 32,
    registers: [
        { multireg:
          { name: "GPIO_DIR",
            count: "GPIORegCount",
            cname: "GPIO_DIR",
            desc: '''
             Set the direction (0 input, 1 output) of the GPIO. Each bit controls one of the
             32 GPIOs where the LSB corresponds to GPIO0.
          '''
            swaccess: "rw",
            hwaccess: "hro",
            fields: [
                {
                    bits: "31:0"
                }
            ]
          }
        }
        {reserved: 32}
        { multireg:
          { name: "GPIO_EN",
            cname: "GPIO_EN",
            count: "GPIORegCount",
            desc: "Enable sampling on the corresponding GPIO",
            swaccess: "rw",
            hwaccess: "hro",
            fields: [
                {
                    bits: "31:0"
                }
            ]
          }
        }
        {reserved: 32}
        { multireg:
          { name: "GPIO_IN",
            cname: "GPIO_IN",
            count: "GPIORegCount",
            desc: "Read the current input values of all GPIOs."
            swaccess: "ro",
            hwaccess: "hwo",
            hwext: true
            fields: [
                {
                    bits: "31:0"
                }
            ]
          }
        }
        {reserved: 32}
        { multireg:
          { name: "GPIO_OUT",
            cname: "GPIO_OUT",
            count: "GPIORegCount",
            desc: "Set the output value of all GPIOs."
            swaccess: "rw",
            hwaccess: "hrw",
            fields: [
                {
                    bits: "31:0"
                }
            ]
          }
        }
        {reserved: 32}
        { multireg:
          { name: "GPIO_SET",
            cname: "GPIO_SET",
            count: "GPIORegCount",
            desc: "For each asserted bit in this register, set the corresponding bit in the padout register."
            swaccess: "wo",
            hwaccess: "hro",
            hwqe: true,
            hwext: true,
            fields: [
                {
                    bits: "31:0"
                }
            ]
          }
        }
        {reserved: 32}
        { multireg:
          { name: "GPIO_CLEAR",
            cname: "GPIO_CLEAR",
            count: "GPIORegCount",
            desc: "For each asserted bit in this register, clear the corresponding bit in the padout register."
            swaccess: "wo",
            hwaccess: "hro",
            hwqe: true,
            hwext: true,
            fields: [
                {
                    bits: "31:0"
                }
            ]
          }
        }
        {reserved: 32}
        { multireg:
          { name: "GPIO_TOGGLE",
            cname: "GPIO_TOGGLE",
            count: "GPIORegCount",
            desc: "For each asserted bit in this register, toggle the corresponding bit in the padout register."
            swaccess: "wo",
            hwaccess: "hro",
            hwqe: true,
            hwext: true,
            fields: [
                {
                    bits: "31:0"
                }
            ]
          }
        }
        {reserved: 32}
        { multireg:
          { name: "INTRPT_RISE_EN",
            cname: "INTRPT_RISE_EN",
            count: "GPIORegCount",
            desc: "Enable Interrupts on rising edges for the corresponding GPIO"
            swaccess: "rw",
            hwaccess: "hro",
            fields: [
                {
                    bits: "31:0"
                }
            ]
          }
        }
        {reserved: 32}
        { multireg:
          { name: "INTRPT_FALL_EN",
            cname: "INTRPT_FALL_EN",
            count: "GPIORegCount",
            desc: "Enable Interrupts on falling edges for the corresponding GPIO"
            swaccess: "rw",
            hwaccess: "hro",
            fields: [
                {
                    bits: "31:0"
                }
            ]
          }
        }
        {reserved: 32}
        { multireg:
          { name: "INTRPT_STATUS",
            cname: "INTRPT_STATUS",
            count: "GPIORegCount",
            desc: "Report pending interrupts on corresponding GPIOs. Writing 1 to the register clears its content."
            swaccess: "rw1c",
            hwaccess: "hrw",
            fields: [
                {
                    bits: "31:0"
                }
            ]
          }
        }
    ]
}
